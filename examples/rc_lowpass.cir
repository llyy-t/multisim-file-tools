* RC low-pass demo deck for msim-cli
V1 in 0 DC 0 PULSE(0 5 0 1n 1n 0.5m 1m) AC 1
R1 in out 1k
C1 out 0 100n
.end
